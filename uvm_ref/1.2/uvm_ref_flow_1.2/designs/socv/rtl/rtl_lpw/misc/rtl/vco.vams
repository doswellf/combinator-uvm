//File name   : vdo.v
//Title       :
//Created     : 1999
//Description :
//Notes       :
//----------------------------------------------------------------------
//   Copyright 1999-2010 Cadence Design Systems, Inc.
//   All Rights Reserved Worldwide
//
//   Licensed under the Apache License, Version 2.0 (the
//   "License"); you may not use this file except in
//   compliance with the License.  You may obtain a copy of
//   the License at
//
//       http://www.apache.org/licenses/LICENSE-2.0
//
//   Unless required by applicable law or agreed to in
//   writing, software distributed under the License is
//   distributed on an "AS IS" BASIS, WITHOUT WARRANTIES OR
//   CONDITIONS OF ANY KIND, either express or implied.  See
//   the License for the specific language governing
//   permissions and limitations under the License.
//----------------------------------------------------------------------
module vco(vin, clk);
input vin;
output clk;
wreal vin;

reg clk;

parameter real center_freq= 2.5; // in MHZ
parameter real vco_gain = 10;   // volts/MHZ

   real clk_delay;
   real freq;

  initial
    begin
      clk = 0;
      freq = center_freq;
      clk_delay = 1.0/(2*freq);
    end

  always @(vin)
    begin
      freq = center_freq + vco_gain*vin;
      clk_delay = 1.0/(2*freq) * 1000;
    end

  always #clk_delay
    clk = ~clk;

endmodule
